println("NETLIST_ONLY_START")
envSetVal("asimenv.startup" "projectDir" 'string "@ROOT@/batch_netlisting")
simulator('spectre)
design("@LIB@" "rc_lpf" "schematic")
resultsDir("@ROOT@/batch_results")
temp(27)
analysis('ac ?start @AC_START@ ?stop @AC_STOP@ ?dec @AC_POINTS@)
analysis('tran ?stop @TRAN_STOP@ ?errpreset "conservative" ?maxstep "@MAX_STEP@")
nl=createNetlist(?recreateAll t)
println(list("NETLIST_ONLY_RESULT" nl))
unless(nl error("NETLIST_ONLY_FAILED"))
println("NETLIST_ONLY_DONE")
exit()
